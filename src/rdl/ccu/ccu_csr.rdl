addrmap ccu_csr #(
    //  One counter per hardware event
    longint unsigned numPerfCounters = 64
) {
    name = "CCU control and status registers";

    reg perf_eventsel_r {
        name = "Performance Event Selector";
        desc = "Selects the microarchitectural event to monitor.";
        regwidth = 32;

        field {
            name = "Event Code";
            desc = "Hardware event ID.";
            sw = rw;
            hw = r;
            fieldwidth = 8;
        } event_id = 0;
    };

    reg perf_counter_r {
        name = "Performance Counter";
        desc = "32-bit counter value incremented by the hardware.";
        regwidth = 32;

        field {
            name = "Count";
            sw = rw;
            hw = r;
            counter;
            fieldwidth = 32;
        } cnt = 0;
    };

    reg perf_countinhibit_r {
        name = "Counter Inhibit";
        desc = "Bit [i] = 1 means counter [i] is STOPPED. Bit [i] = 0 lets it
                run. One register per 32 counters.";
        regwidth = 32;

        field {
            name = "Inhibit Bitmask";
            sw = rw;
            hw = r;
            fieldwidth = 32;
        } inh = (1 << 32) - 1;
    };

    reg ctrl_r {
        name = "Static Configuration";
        desc = "Static configuration bits for the CCU features.";
        regwidth = 32;

        field {
            name = "Snoop Filter Enable";
            sw = rw;
            hw = r;
            fieldwidth = 1;
        } snoop_filter_en = 1;
    };

    // --- Memory Map Instantiation ---

    // Global Control @ 0x00, one register per 32 counters
    perf_countinhibit_r perf_countinhibit[numPerfCounters / 32] @ 0x00;

    // Array of Event Selectors @ 0x40
    perf_eventsel_r perf_eventsel[numPerfCounters] @ 0x40;

    // Array of 32-bit Counters @ 0x140
    perf_counter_r perf_counter[numPerfCounters] @ 0x140;

    // Control register
    ctrl_r ctrl;
};
